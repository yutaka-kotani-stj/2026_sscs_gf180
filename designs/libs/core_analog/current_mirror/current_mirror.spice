** sch_path: /foss/designs/03_super_long_wave/2026_sscs_gf180/designs/libs/core_analog/current_mirror/current_mirror.sch
.subckt current_mirror VDD IB_IN IB_OUT
*.PININFO VDD:I IB_IN:I IB_OUT:O
M4 IB_IN IB_IN VDD VDD pfet_03v3 L=4u W=48u nf=1
M7 IB_OUT IB_IN VDD VDD pfet_03v3 L=4u W=48u nf=1
.ends
