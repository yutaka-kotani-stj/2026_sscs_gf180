** sch_path: /foss/designs/03_super_long_wave/2026_sscs_gf180/designs/libs/core_analog/bmr/bmr.sch
.subckt bmr VDD VSS 64uA_OUT
*.PININFO VDD:I VSS:I 64uA_OUT:O
M3 net2 net1 net3 GND nfet_03v3 L=1u W=10u nf=1
M5 net3 net2 VDD VDD pfet_03v3 L=3u W=15u nf=1
M6 net1 net1 VDD VDD pfet_03v3 L=4u W=4u nf=1
M9 net2 net3 net4 net4 nfet_03v3 L=3u W=10u nf=1
M12 net2 net2 VDD VDD pfet_03v3 L=3u W=15u nf=1
M1 net1 net3 VSS VSS nfet_03v3 L=3u W=10u nf=1
M2 net3 net3 VSS VSS nfet_03v3 L=3u W=5u nf=1
M4 64uA_OUT net2 VDD VDD pfet_03v3 L=3u W=14u nf=1
XR1 VSS net4 VDD ppolyf_u_3k r_width=1e-6 r_length=1e-6
.ends
.GLOBAL GND
