** sch_path: /foss/designs/03_super_long_wave/2026_sscs_gf180/designs/libs/core_analog/sw_matrix/sw_matrix_25x1.sch
.subckt sw_matrix_25x1 COL15 COL0 COL20 COL5 COL10 VDD COL6 VSS COL11 COL1 COL21 COL16 COL22 COL2 COL17 COL12 RESET_N COL7 COL18
+ COL3 COL13 CLK COL8 COL23 COL19 CS_N COL14 COL24 COL9 COL4 DIN DOUT ROW
*.PININFO VDD:I VSS:I RESET_N:I CLK:I CS_N:I DIN:I COL0:B COL1:B COL2:B COL3:B COL4:B ROW:B DOUT:O COL5:B COL6:B COL7:B COL8:B
*+ COL9:B COL10:B COL11:B COL12:B COL13:B COL14:B COL15:B COL16:B COL17:B COL18:B COL19:B COL20:B COL21:B COL22:B COL23:B COL24:B
x1 VDD VSS RESET_N1 CLK1 CS_N1 DIN Q20 COL20 COL21 COL22 COL23 COL24 ROW sw_matrix_5x1
x5 CLK CLK1 VDD VDD VSS VSS gf180mcu_fd_sc_mcu7t5v0__clkbuf_16
x13 RESET_N RESET_N1 VDD VDD VSS VSS gf180mcu_fd_sc_mcu7t5v0__clkbuf_16
x6 CS_N CS_N1 VDD VDD VSS VSS gf180mcu_fd_sc_mcu7t5v0__clkbuf_16
x2 VDD VSS RESET_N1 CLK1 CS_N1 Q20 Q15 COL15 COL16 COL17 COL18 COL19 ROW sw_matrix_5x1
x3 VDD VSS RESET_N1 CLK1 CS_N1 Q15 Q10 COL10 COL11 COL12 COL13 COL14 ROW sw_matrix_5x1
x4 VDD VSS RESET_N1 CLK1 CS_N1 Q10 Q5 COL5 COL6 COL7 COL8 COL9 ROW sw_matrix_5x1
x7 VDD VSS RESET_N1 CLK1 CS_N1 Q5 DOUT COL0 COL1 COL2 COL3 COL4 ROW sw_matrix_5x1
**** begin user architecture code

.include /foss/pdks/gf180mcuD/libs.ref/gf180mcu_fd_sc_mcu7t5v0/spice/gf180mcu_fd_sc_mcu7t5v0.spice

**** end user architecture code
.ends

* expanding   symbol:  libs/core_analog/sw_matrix/sw_matrix_5x1.sym # of pins=13
** sym_path: /foss/designs/03_super_long_wave/2026_sscs_gf180/designs/libs/core_analog/sw_matrix/sw_matrix_5x1.sym
** sch_path: /foss/designs/03_super_long_wave/2026_sscs_gf180/designs/libs/core_analog/sw_matrix/sw_matrix_5x1.sch
.subckt sw_matrix_5x1 VDD VSS RESET_N CLK CS_N DIN DOUT COL_A COL_B COL_C COL_D COL_E ROW
*.PININFO VDD:I VSS:I RESET_N:I CLK:I CS_N:I DIN:I COL_A:B COL_B:B COL_C:B COL_D:B ROW:B DOUT:O COL_E:B
x1 VDD VSS RESET_N1 CLK1 DIN CS_N1 Q_E COL_E ROW sw_matrix_cell
x5 VDD VSS RESET_N1 CLK1 Q_E CS_N1 Q_D COL_D ROW sw_matrix_cell
x6 VDD VSS RESET_N1 CLK1 Q_D CS_N1 Q_C COL_C ROW sw_matrix_cell
x7 VDD VSS RESET_N1 CLK1 Q_C CS_N1 Q_B COL_B ROW sw_matrix_cell
x11 VDD VSS RESET_N1 CLK1 Q_B CS_N1 DOUT COL_A ROW sw_matrix_cell
x3 CLK CLK1 VDD VDD VSS VSS gf180mcu_fd_sc_mcu7t5v0__clkbuf_16
x13 RESET_N RESET_N1 VDD VDD VSS VSS gf180mcu_fd_sc_mcu7t5v0__clkbuf_16
x2 CS_N CS_N1 VDD VDD VSS VSS gf180mcu_fd_sc_mcu7t5v0__clkbuf_16
.ends

* expanding   symbol:  libs/core_analog/sw_matrix/sw_matrix_cell.sym # of pins=9
** sym_path: /foss/designs/03_super_long_wave/2026_sscs_gf180/designs/libs/core_analog/sw_matrix/sw_matrix_cell.sym
** sch_path: /foss/designs/03_super_long_wave/2026_sscs_gf180/designs/libs/core_analog/sw_matrix/sw_matrix_cell.sch
.subckt sw_matrix_cell VDD VSS RESET_N CLK D CS_N Q COL ROW
*.PININFO RESET_N:I CLK:I D:I CS_N:I VSS:I VDD:I Q:O COL:B ROW:B
x14 VDD VSS COL net1 ROW net2 trans_gate
x3 net2 net1 VDD VDD VSS VSS gf180mcu_fd_sc_mcu7t5v0__clkinv_1
x4 VDD VSS RESET_N CLK D CS_N Q net2 sreg
.ends

* expanding   symbol:  libs/core_analog/trans_gate/trans_gate.sym # of pins=6
** sym_path: /foss/designs/03_super_long_wave/2026_sscs_gf180/designs/libs/core_analog/trans_gate/trans_gate.sym
** sch_path: /foss/designs/03_super_long_wave/2026_sscs_gf180/designs/libs/core_analog/trans_gate/trans_gate.sch
.subckt trans_gate VNW VPW A ENB Y EN
*.PININFO EN:I ENB:I VNW:B VPW:B Y:B A:B
M1 A ENB Y VNW pfet_03v3 L=0.28u W=60u nf=1
M2 A EN Y VPW nfet_03v3 L=0.28u W=20u nf=1
.ends

* expanding   symbol:  libs/core_analog/sreg/sreg.sym # of pins=8
** sym_path: /foss/designs/03_super_long_wave/2026_sscs_gf180/designs/libs/core_analog/sreg/sreg.sym
** sch_path: /foss/designs/03_super_long_wave/2026_sscs_gf180/designs/libs/core_analog/sreg/sreg.sch
.subckt sreg VDD VSS RESET_N CLK D CS_N Q OUT
*.PININFO RESET_N:I CLK:I D:I CS_N:I VSS:I VDD:I Q:O OUT:O
x11 net1 RESET_N CLK Q VDD VDD VSS VSS gf180mcu_fd_sc_mcu7t5v0__dffrnq_1
x15 net2 RESET_N CS_N OUT VDD VDD VSS VSS gf180mcu_fd_sc_mcu7t5v0__dffrnq_1
x1 D Q CS_N net1 VDD VDD VSS VSS gf180mcu_fd_sc_mcu7t5v0__mux2_2
x2 Q OUT CS_N net2 VDD VDD VSS VSS gf180mcu_fd_sc_mcu7t5v0__mux2_2
.ends
