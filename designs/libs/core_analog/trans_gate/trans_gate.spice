** sch_path: /foss/designs/03_super_long_wave/2026_sscs_gf180/designs/libs/tb_digital/tb_sw_matrix_system/trans_gate/trans_gate.sch
.subckt trans_gate VNW VPW A ENB Y EN
*.PININFO EN:I ENB:I VNW:B VPW:B Y:B A:B
M1 A ENB Y VNW pfet_03v3 L=0.28u W=60u nf=1
M2 A EN Y VPW nfet_03v3 L=0.28u W=20u nf=1
.ends
